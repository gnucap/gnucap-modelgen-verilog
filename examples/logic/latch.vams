discipline logic;
  domain discrete;
enddiscipline;
module clock(out, en);
  output out;
  input en;
  logic out, en;
  assign #15 out = !(out & en);
endmodule
module latch(q, r, s)
  input r, s;
  output q;
  logic q, r, s;
  assign #2 q = r & ( ( q & r & s ) | !s );
endmodule
