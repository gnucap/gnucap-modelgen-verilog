nature current
  access = I;
  units = "A";
  abstol = 1e-12; // OPT::abstol
endnature

// Electrical potential
nature voltage
  access = V;
  units = "V";
  abstol = 1e-6; // OPT::vntol
endnature

// Electrical discipline
discipline electrical
  potential voltage;
  flow current;
enddiscipline

module trln0(out0, out1, in0, in1)
	electrical out0, out1;
	electrical in0, in1;
	electrical fwd, ref;
	branch (out0, out1) out;
	branch (in0, in1) in;
	parameter real pp = -1e2;
	parameter real z0 = 50.;
//	(*desc="v"*)
	real vref, vfwd;
	analog begin

		vfwd = laplace_np(2.*V(in)-V(ref) , '{ 1,-.01},
                                          '{-5,0,pp,5,pp,-5, .5*pp,.9,.5*pp,-.9});
		vref = laplace_np(2.*V(out)-V(fwd), '{ 1,-.01},
                                          '{-5,0,pp,5,pp,-5, .5*pp,.9,.5*pp,-.9});

		I(fwd) <+ V(fwd) - vfwd;
		I(ref) <+ V(ref) - vref;

		I(out) <+ (V(out) - vfwd)/z0;
		I(in) <+ (V(in) - vref)/z0;
	end
endmodule
