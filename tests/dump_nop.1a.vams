`include "disciplines.vams"
`pragma modelgen nodump-unreachable
`pragma modelgen nodump-nature
`pragma modelgen nodump-discipline

module test(a, b);
	electrical a, b;
	parameter real arg=0 from [0.:0.];
	real T;
	real U;
	analog begin : main
		real x;
		if(0)
			V(a) <+ 1.;
		else
			V(a) <+ 1.1;

		if(!arg)
			V(b) <+ 2.;
		else
			V(b) <+ 2.1;

		if(arg)
			V(b) <+ 3.;
		else
			V(b) <+ 3.1;

		if(T)
			V(b) <+ 3.9;
		else
			V(b) <+ 3.7;

		if(0==1)
			V(a) <+ 4.;

		x = 0.;
		if(x)
			V(a) <+ 5.;

		case(arg)
			0: V(b) <+ 1.2;
			default:
		endcase

		case(arg)
			0: V(b) <+ 2.0;
			1: V(b) <+ 2.1;
			default: V(b) <+ 2.2;
		endcase
	end
endmodule
