`include "sub/disciplines.few"
`pragma modelgen nodump-unreachable

module test(a, b);
	electrical a, b;
	parameter real arg=0 from [0.:0.];
	real T;
	real U;
	analog begin
		if(0)
			V(a) <+ 1.;
		else
			V(a) <+ 2.;

		if(arg)
			V(b) <+ 3.;

		if(0==1)
			V(a) <+ 4.;

		real x;
		x = 0.;
		if(x)
			V(a) <+ 5.;

		case(arg)
			0: V(b) <+ 1.2;
			default:
		endcase

		case(arg)
			0: V(b) <+ 2.0;
			1: V(b) <+ 2.1;
			default: V(b) <+ 2.2;
		endcase
	end
endmodule
