module test

 analog begin : main
  real a;
  begin : scopename
 	real b;
  end
 end

 analog begin : stuff
  real x;
 end

endmodule
