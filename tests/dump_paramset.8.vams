`include "sub/disciplines.few"
`pragma modelgen noexpand-paramset
`pragma modelgen nodump-discipline
`pragma modelgen nodump-nature

module resistor(a,b)
	electrical a, b;
	(*desc="x"*) real x;
endmodule

paramset const_res resistor;
	(*desc="a"*) real a;
	real b;
	a = 1 + .x;
endparamset;
