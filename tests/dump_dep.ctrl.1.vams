`include "disciplines.vams"
`include "constants.vams"
`pragma modelgen dump-annotate
`pragma modelgen nodump-nature
`pragma modelgen nodump-discipline

module test_while0a(p, n);
	electrical p, n;
	inout p, n;
	parameter real r=0;
	analog begin : main
		integer i;
		real x;
		real y;
		x = 0.;
		y = 0.;
		i = r;
		while(i>0) begin
			i = i - 1;
			x = y;
			y = x + V(p, n);
		end

		I(p, n) <+ x;
	end
endmodule
