`include "sub/disciplines.few"

module commatest (a, b, gnd);
	parameter real x=0 from [1,2];
	parameter real y=0 from [1:2];
endmodule;
