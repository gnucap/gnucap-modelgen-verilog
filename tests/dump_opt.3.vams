`include "disciplines.vams"
`include "constants.vams"
`pragma modelgen dump-annotate
`pragma modelgen nodump-nature
`pragma modelgen nodump-discipline
`pragma modelgen nodump-unreachable

module test_opt3(np, n);
   electrical p, n;
   inout p, n;
   analog begin
		I(p,n) <+ 0.;
		I(p,n) <+ ddt(0. * V(p,n));
		I(p,n) <+ 0. * ddt(V(p,n));
   end
endmodule
