`include "disciplines.vams"
`pragma modelgen nodump-nature
`pragma modelgen nodump-discipline

module test_array(p, n);
	(* desc="" *) real dv;
	electrical p, n;
	analog begin
		dv = '{1,2,3};
		dv = ddt(V(p,n), '{1, 0});
	end
endmodule
