module test

// real a;
 integer a;
 analog begin
  begin : scopename
 	a = 1;
  end
 end
 analog begin
  begin
   begin
 	 a = 1;
   end
  end
 end
 analog begin
  begin
   begin
    begin
 	  a = 1;
    end
   end
  end
 end

endmodule
