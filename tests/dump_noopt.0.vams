`pragma modelgen nooptimize-binop

module test(d, g, s, b);
	electrical d, g;
	real T, U;
	parameter real P = 3;
	analog begin
		T = 0 * P;
		T = 0 * U;
		T = 2.0 * U * 3.0 / 5.;
		T = 2.0 * P * 3.0 / 5.;
		T = 2.0 * U * 3.0 / 5. * ln(1.0 + 0.4e-6 / T);
		T = 2.0 * P * 3.0 / 5. * ln(1.0 + 0.4e-6 / T);
	end
endmodule
