module test()

	parameter real a = 1.;
	parameter real b = 1.;

	aliasparam b = a;

endmodule
