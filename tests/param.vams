`include "sub/disciplines.few"

module device(p,n);
	inout p,n;

	parameter real c=1.; //  from [0:inf);
	parameter real d=1., e=2;
	parameter integer i=0, j=10;
	localparam real l1=0, l2=10;
	localparam	real t1=0, t2=10;
	analog begin
	end
endmodule
