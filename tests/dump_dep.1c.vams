`include "disciplines.vams"
`include "constants.vams"
`pragma modelgen dump-annotate
`pragma modelgen nodump-nature
`pragma modelgen nodump-discipline

module dep0(d, g);
  inout      d, g;
  electrical d, g;
  analog begin : main
    real c;
    real T;
    real S;
    integer k;
    S = V(g);
    k = 10;
    while(k) begin
      c = S;
      T = c;
		c = 0;
		k = k-1;
    end
  end

endmodule
