`include "disciplines.vams"
`include "constants.vams"
`pragma modelgen dump-annotate
`pragma modelgen nodump-nature
`pragma modelgen nodump-discipline

module st(p);
  inout      p;
  electrical p;
  (* _state *) real d;
  analog begin : main
    real c;
    c = c + 1;
    d = c;
  end

endmodule
