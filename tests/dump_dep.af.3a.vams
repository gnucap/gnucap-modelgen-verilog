`include "disciplines.vams"
`include "constants.vams"
`pragma modelgen dump-annotate
`pragma modelgen nodump-nature
`pragma modelgen nodump-discipline

module test_af_1a(p, n);
	electrical p, n;
	parameter real v = 1;

	analog function real fct;
		inout x;
		integer x;
		begin
			x = exp(x);
		end
	endfunction

	analog begin : main
		integer xxint;
		xxint = v;
		V(p, n) <+ fct(xxint);
	end
endmodule
