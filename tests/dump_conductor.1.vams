// Linear resistor (conductance formulation)
// kk-3-02.vams

`include "disciplines.vams"

module conductor (p, n);
	parameter real g=0;	// conductance (Siemens)
	inout p, n;
	electrical p, n;

	analog
		I(p,n) <+ g * V(p,n);
endmodule
