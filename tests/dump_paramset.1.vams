`include "sub/disciplines.few"
`pragma modelgen noexpand-paramset

module resistor(a,b)
	electrical a, b;

	parameter real r = 1. from (0:inf);

	analog begin
		I(a,b) <+ V(a,b)/r;
	end
endmodule

paramset my_res resistor;
	parameter real R = 1.;
	.r = R;
endparamset;

paramset my_res resistor;
	parameter real R0 = 1.;
	parameter real R1 = 1.;
	.r = R0+R1;
endparamset;
