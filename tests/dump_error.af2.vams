`include "sub/disciplines.few"

module test_af(a,b)
  electrical a, b;
  real modulevar;

  analog function real xs;
      input x;
      real x;
      begin
        x = modulevar; // invalid.
      end
  endfunction

  analog begin
  end

endmodule
