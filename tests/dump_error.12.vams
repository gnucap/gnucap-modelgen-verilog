`include "disciplines.vams"
`include "constants.vams"
`pragma modelgen nodump-nature
`pragma modelgen nodump-discipline
`pragma modelgen nodump-unreachable

module test_probe(a, c);
	inout a, c;
	electrical a, c;
	parameter real x=0;

	analog begin : main
		real a, b;

		if(x <= 0.) begin
			a = V(a, c); // a not used.
		end else begin
			a = I(a, c);
			b = a; // b is not used
		end

		// still illegal, c.f. 5.4.2.1

	end
endmodule
