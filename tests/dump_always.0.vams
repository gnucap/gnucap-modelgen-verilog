module test
 always begin : stuff
 end
endmodule
