discipline logic;
 domain discrete;
enddiscipline;
module test(L);
 logic L;
 always begin : stuff
 end
 always @(L) begin
 end
 always begin
    @(L) begin end
 end
endmodule
