`include "sub/disciplines.few"

module branchtest(a, b);
	electrical a, b, c;
	branch (a, b) mybr1, mybr1_alias;
	branch (c, b) mybr2;
	branch (b, c) mybr3;

	analog begin
		I(a,b) <+ 1.;
		I(b,a) <+ 2.;
		I(mybr2) <+ 3.;
		I(mybr3) <+ 4.;
	end
endmodule
