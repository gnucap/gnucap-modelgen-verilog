module loops

  analog begin : main
    real i;
    i=5;
    while(i) begin
      i = i - 1;
    end
    for(i=9; i>4; i=i-1) begin
      i = i - 1;
    end
    for( ; i>0; i=i-1) begin
      i = i - 1;
    end
    for( ; i>0; ) begin
      i = i - 1;
    end
   end

endmodule
