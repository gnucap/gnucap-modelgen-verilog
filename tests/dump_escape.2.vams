module test()

analog begin
	real arg;
	$strobe("... %f with escaped escape \\", arg);
end

endmodule
