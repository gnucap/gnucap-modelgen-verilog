module test()

analog begin : main
	real arg;
	$strobe("... %f with escaped escape \\", arg);
end

endmodule
