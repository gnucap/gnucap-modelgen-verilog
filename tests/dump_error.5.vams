`include "sub/disciplines.few"

module test(n, p)
electrical n, p;
	analog begin
		XS(n, p) <+ 17.
	end
endmodule
