`include "sub/disciplines.few"
`pragma modelgen nodump-nature
`pragma modelgen nodump-discipline

module test (p, n);
	inout p, n;
	electrical p, n;

	parameter real a = 2.;
	real x[3:74];
	real b = 2*a;
	real y[0:2] = '{exp(0.),a,3.};

	analog begin
		y = '{1,2,3}; //  + '{1,2,3};
		I(p,n) <+ b;
	end

endmodule
