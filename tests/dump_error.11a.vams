module resistor();
endmodule;
module resistor();
endmodule;

paramset const_res resistor;
	parameter real rr = 0.;
	.r = 1;
endparamset;
