`include "sub/disciplines.few"

module test_ind1(out, in)
	electrical out, in;

	analog begin
		V(out) : V(in) == 0.;
	end

endmodule
