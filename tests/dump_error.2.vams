`include "sub/disciplines.few"

module test()
	real i;
	analog begin
	for(i=1; i>0; i=j) begin
	end
endmodule;
