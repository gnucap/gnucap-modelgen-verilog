`include "sub/disciplines.few"
`pragma modelgen expand-paramset

module resistor(a,b)
	electrical a, b;

	parameter real r = 1.;

	analog begin
		I(a,b) <+ V(a,b)/r;
	end
endmodule

paramset my_res resistor;
	parameter real R = 1. from [1.:1.];
	.r = R;
endparamset;
