`include "disciplines.vams"
`include "constants.vams"
`pragma modelgen dump-annotate
`pragma modelgen nodump-nature
`pragma modelgen nodump-discipline

module test();
	electrical p, n;

	analog function real fct;
		inout x;
		integer x;
		begin
			x = 2;
		end
	endfunction

	analog begin : main
		integer xxint;
		xxint = 1;
		V(p, n) <+ fct(xxint);
	end
endmodule
