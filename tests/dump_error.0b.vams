`include "sub/disciplines.few"
`pragma modelgen nodump-module
`pragma modelgen noexpand-paramset

module error0b (p, n);
	inout p, n;
	electrical p, n;
	real v;

	analog
		if(1) begin
			bogus(17);
      end
endmodule
