`include "disciplines.vams"
`include "constants.vams"
`pragma modelgen dump-annotate
`pragma modelgen nodump-nature
`pragma modelgen nodump-discipline

module dep0(d, g);
  inout      d, g;
  electrical d, g;
  analog function real testaf;
    real a, b;
    input a;
    inout b;
    begin
       b = a;
       testaf = a;
    end
  endfunction

  analog begin: main
    real a;
    real b;
    real c;
    begin
      a = V(g);
        c = testaf(a, b);
        I(d) <+ b;
        I(g) <+ c;
    end
  end
endmodule
