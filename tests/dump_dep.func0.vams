`include "disciplines.vams"
`include "constants.vams"
`pragma modelgen dump-annotate
`pragma modelgen nodump-nature
`pragma modelgen nodump-discipline

module dep_tern0(d, g);

    inout      d, g;
    electrical d, g;

    analog begin: main
        real c;
        real T;

        c = V(d);
        T = V(g);
        I(d) <+ pow(T,c);

    end

endmodule
