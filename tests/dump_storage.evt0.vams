`include "disciplines.vams"
`include "constants.vams"
`pragma modelgen dump-annotate
`pragma modelgen nodump-nature
`pragma modelgen nodump-discipline

module test_evtana0c(p, n);
	electrical p, n;
	inout p, n;
	integer cnt;
	real v;
	analog begin
		if(analysis("static")) begin
			$debug("static %g\n", $abstime);
			v = .4;
		end else begin
			if(0) $trace("not static %g\n", $abstime);
			@(timer(0., .5)) begin
				v = 1;
				cnt = cnt + 1;
			end
		end
		V(p,n) <+ v;
	end
endmodule
