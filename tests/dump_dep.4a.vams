`include "disciplines.vams"
`include "constants.vams"
`pragma modelgen dump-annotate
`pragma modelgen nodump-unreachable
`pragma modelgen nodump-nature
`pragma modelgen nodump-discipline

module test_nop2(np, n);
   electrical p, n;
   inout p, n;
   analog begin
      if(0.)
         I(p,n) <+ 0. * V(p,n);
   end
endmodule
