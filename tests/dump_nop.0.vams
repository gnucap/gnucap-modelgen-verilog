`include "sub/disciplines.few"

module test(d, g, s, b);
	electrical d, g;
	real T;
	real U;
	analog begin
		T = V(d, g) * 0.;
		T = 0. * V(d, g);
		T = 0. * V(d, g) * exp(T);
		T = 0. * exp(17.);
		T = exp(17.) * 0.;
		T = exp(17.) * (0. + 0.);
		T = exp(17.) * (0. * 0.);
		T = (0. * 0.) * exp(42.);
		T = exp(T) * ln(1);
		T = ln(1) * exp(T);
		T = 0. * exp(V(d, g)+4);
		T = exp(V(d, g)+4) * 0.;
	end
endmodule
