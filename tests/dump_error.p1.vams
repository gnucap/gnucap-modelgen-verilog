module perror0 ();
  parameter real a;
endmodule
