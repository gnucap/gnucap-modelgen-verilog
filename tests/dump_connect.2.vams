`include "sub/disciplines.few"
`pragma modelgen nodump-nature
`pragma modelgen nodump-discipline

`ifdef __VAMS_GNUCAP__
`define edge(a) edge(a)
`else
`define edge(a) a
`endif

connectmodule another_d2a(i, o);
  parameter real vdd = 1.0;
  parameter real slewrate = 2.0/1e-9; // V/s
  input i;
  output o;
  electrical o;
  reg qd_val, // queued value
      nw_val;
  real et;
  // delay to event
  real start_delay;
  // .. to ramp start
  always @(driver_update(i)) begin
    nw_val = $driver_next_state(i,0); // assume one driver
    if (nw_val == qd_val) begin
      // no change (assume delay constant)
    end else begin
      et = $driver_delay(i,0) * 1e-9; // real delay
      qd_val = nw_val;
    end
  end
  analog begin
    @(`edge(qd_val)) begin
      start_delay = et - (vdd/2)/slewrate;
    end
    V(o) <+ vdd * transition(qd_val,start_delay,vdd/slewrate);
  end
endmodule
