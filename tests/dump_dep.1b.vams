`include "disciplines.vams"
`include "constants.vams"
`pragma modelgen dump-annotate
`pragma modelgen nodump-nature
`pragma modelgen nodump-discipline

module dep0(d, g);
  inout      d, g;
  electrical d, g;
  analog begin : main
    real T;
    real S;
    real U;
	 T = T;
	 U = T;
    while(1) begin
      S = T;
      T = V(g);
    end
    T = T;
  end

endmodule
