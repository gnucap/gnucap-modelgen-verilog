`include "sub/disciplines.few"
`pragma modelgen noexpand-paramset

(* attribute="proto" *)
module resistor(a,b)
	electrical a, b;

	(*attrib=yes*) parameter real r = 0.;
	parameter real a = 0, b = 0.;

	analog begin
		I(a,b) <+ V(a,b)/r;
	end
endmodule

(* attribute="stub" *)
paramset const_res resistor;
	parameter real rr = 0., RR = 0.;
	localparam real ll = rr;
	(*attrib=yes*) parameter real xx = 0.;
	.r = 1;
	.a = xx + ll;
endparamset;
