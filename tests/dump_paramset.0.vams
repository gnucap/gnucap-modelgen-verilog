`include "sub/disciplines.few"
`pragma modelgen noexpand-paramset

(* attribute="proto" *)
module resistor(a,b)
	electrical a, b;

	(*attrib=yes*) parameter real r = 0.;
	parameter real aa = 0, bb = 0.;
	parameter integer ii = 0, jj = 0.;

	analog begin
		I(a,b) <+ V(a,b)/r;
	end
endmodule

(* attribute="stub" *)
paramset const_res resistor;
	parameter real rr = 0., RR = 0.;
	localparam real ll = rr;
	(*attrib=yes*) parameter real xx = 0.;
	.r = 1;
	.aa = xx + ll;
	.ii = 0;
	.jj = 0;
endparamset;
