`include "sub/disciplines.few"
module test_pg0(p, n)
   electrical p, n;
   parameter real st = 3;

   analog begin
      if $param_given(st) begin
         V(p,n) <+ 1;
      end else
         V(p,n) <+ 2;
   end

endmodule
