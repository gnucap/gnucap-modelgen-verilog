`include "sub/disciplines.few"

module test_portbranch(p, n)
	electrical p, n;
	real i;

	analog begin
		V(n, p) <+ 0.;
		i = I(<p>);
	end

endmodule
