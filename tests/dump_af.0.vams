module test_af()

analog function real limitex;
    input x;
    real x;
    begin
        if (x > 17.) begin
            limitex = 42. * (1.0+(x)-17.);
        end else if (x < -17.) begin
            limitex = 42.;
        end else begin
            limitex = exp(x);
        end
    end
endfunction

analog function real fct;
    real x;
    input x;
    begin
        fct = ln(max(x , .1));
    end
endfunction

analog function real fct2;
  real x;
  input x;
  real y;
  begin
    y = 1.;
    fct2 = ln(max(x , y));
  end
endfunction

analog function real something;
  input x, y;
  output z;
  real x;
  real y, z;
  begin
        something = 0.5 * (x + sqrt(x*x + 4.0*y*y));
        real r;
  end
endfunction

analog begin
	real i;
	real out;
	i = something(1+5*5, exp(3), out);
	i = something(1+5*5, exp(ln(1)), out);
end

endmodule
