module test()

analog begin
	real arg;
	$strobe("... %f with escaped newline \
                test.", arg);
end

endmodule
