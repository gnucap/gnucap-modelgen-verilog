module test()

	real arg;
analog begin
	$strobe("... %f with escaped newline \
                test.", arg);
end

endmodule
