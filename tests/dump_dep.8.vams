`include "disciplines.vams"
`include "constants.vams"
`pragma modelgen dump-annotate
`pragma modelgen nodump-nature
`pragma modelgen nodump-discipline
`pragma modelgen expand-paramset

module dep7(a, g);
  inout      a, g;
  electrical a, g;
  real T;
  parameter real p = 0.;
  analog begin : main
    real c, d;
    c = V(a);
    if(V(g)>1) begin : b0
      real t;
      t = 4;
    end else begin
      d = c;
    end
    begin : stuff
      if(c > 0) begin : b1
        real f;
        I(g) <+ d;
        f = d;
      end else begin
        I(g) <+ 1;
      end
    end
  end
endmodule

paramset dep7p dep7
endparamset
