`include "sub/disciplines.few"

module device(p,n);
	inout p,n;

	parameter real c=1.; //  from [0:inf);
	localparam real l1=c+5, l2=10;
	parameter real d=1., e=2;
	parameter integer i=0, j=10;
	localparam	real t1=exp(l1), t2=10;
	analog begin
	end
endmodule
