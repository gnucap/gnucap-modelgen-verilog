`include "disciplines.vams"
`include "constants.vams"
`pragma modelgen dump-annotate
`pragma modelgen nodump-nature
`pragma modelgen nodump-discipline

module dep13(d, g);
  inout      d, g;
  electrical d, g;
  real T;
  parameter real p = 0.;
  real tmp;
  real c;
  analog begin : main
	 if (p != 0) begin
		  tmp = p;
        c = tmp;
    end
    T = c;
    I(d,g)<+c;
  end

endmodule
