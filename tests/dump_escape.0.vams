module test()

	analog begin : main
		real arg;
		$strobe("an %f escaped \"`string\" test.", arg);
	end

endmodule
