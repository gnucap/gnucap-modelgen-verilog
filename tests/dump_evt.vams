`include "sub/disciplines.few"
`pragma modelgen dump-annotate

module device(p,n);
	inout p,n;
	real r;

	analog begin
		@(initial_step) r=3;
	end
	analog begin
		@(initial_step) begin
			r=2;
		end
		@(final_step) begin
			r=1;
		end
	end
endmodule
