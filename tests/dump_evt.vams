`include "sub/disciplines.few"

module device(p,n);
	inout p,n;
	real r;

	analog begin
		@(initial_step) r=3;
	end
	analog begin
		@(initial_step) begin
			r=2;
		end
	end
endmodule
