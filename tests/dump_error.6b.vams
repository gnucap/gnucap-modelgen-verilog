module test()
	real a=1;
	real a=1;
endmodule
