`include "disciplines.vams"
`include "constants.vams"
`pragma modelgen dump-annotate
`pragma modelgen nodump-nature
`pragma modelgen nodump-discipline

module dep11(p, n);
	electrical p, n;
	inout p, n;
	real a, b;
	parameter real p = 1.;
	analog begin
		a = V(n, p);
		b = 1.;
		b = -a*b*b;
		I(p,n) <+ ln(exp(-a * b));
	end
endmodule
