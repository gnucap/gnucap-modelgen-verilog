`include "disciplines.vams"
`include "constants.vams"
`pragma modelgen dump-annotate
`pragma modelgen nodump-nature
`pragma modelgen nodump-discipline

module dep0(d, g);

    inout      d, g;
    electrical d, g;

		real beginvar=0;

    analog begin : main
    end
    analog beginvar = 0;

endmodule
