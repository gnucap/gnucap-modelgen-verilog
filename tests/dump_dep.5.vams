`include "disciplines.vams"
`include "constants.vams"
`pragma modelgen dump-annotate
`pragma modelgen nodump-nature
`pragma modelgen nodump-discipline

module test_dep5(np, n);
   electrical p, n;
   inout p, n;
   analog begin : main
		real AA;
		AA = V(p,n);
		I(p,n) <+ ddt(AA * V(p,n));
   end
endmodule
