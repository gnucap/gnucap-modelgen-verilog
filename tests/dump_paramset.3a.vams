`include "sub/disciplines.few"
`pragma modelgen expand-paramset
`pragma modelgen nodump-module
`pragma modelgen dump-paramset

module resistor(a,b)
	electrical a, b;

	parameter real r = 1.;
	real g;
	real i;
	real alpha;

	analog begin
		alpha = 1.;
		if(r) begin
			g = alpha/r;
		end
		I(a,b) <+ V(a,b)*g;
		begin
			i=3.;
			if(1)
				i=4;
		end
	end
endmodule

paramset my_res resistor;
	parameter real g = 1;
	.r = 1./g;
endparamset;
