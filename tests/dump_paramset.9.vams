`include "sub/disciplines.few"
`pragma modelgen noexpand-paramset
`pragma modelgen dump-module
`pragma modelgen nodump-nature
`pragma modelgen nodump-discipline

module resistor(a,b)
	electrical a, b;

	parameter real t = 0;
	integer T;

	analog begin
    begin : initial_model
        if (t >= 0) begin
            T = 1;
        end else begin
            T = -1;
        end
	  end
	end
endmodule

paramset const_res resistor;
	.t = 1;
endparamset;
