`include "disciplines.vams"
`include "constants.vams"
`pragma modelgen dump-annotate
`pragma modelgen nodump-nature
`pragma modelgen nodump-discipline

module dep_test(d, g);

  inout      d, g;
  electrical d, g;
  parameter integer sel = 0 from [0:2];

  analog begin: main
    real c;
    case(sel)
      0: c=1;
      1: c=sel;
      default: c=17;
    endcase

	 I(d) <+ c;
    c = 4;
  end
endmodule
