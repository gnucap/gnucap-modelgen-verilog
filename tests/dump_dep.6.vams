`include "disciplines.vams"
`include "constants.vams"
`pragma modelgen dump-annotate
`pragma modelgen nodump-nature
`pragma modelgen nodump-discipline

module dep6(d, g);
  inout      d, g;
  electrical d, g;
  analog begin : main
    real c;
    real T, S, U;
    @(initial_step) begin
      c=1.;
    end
    @(initial_step) c=2.;
	 T = c;
    S = T*T;
    U = exp(c);
  end

endmodule
