`include "disciplines.vams"
`include "constants.vams"
`pragma modelgen dump-annotate
`pragma modelgen nodump-nature
`pragma modelgen nodump-discipline

module dep0(d, g);

    inout      d, g;
    electrical d, g;

    analog begin: main
        real c;
        real T;

        c = T;
        T = V(g);
        I(d) <+ c;
        I(g) <+ V(g);

    end

endmodule
