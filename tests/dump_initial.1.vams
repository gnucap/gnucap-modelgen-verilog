`pragma modelgen dump-annotate
`pragma modelgen nodump-nature
`pragma modelgen nodump-discipline

module test();
	real T;
	analog initial T = 1;

	analog initial begin
		if(T == 1) T = 2;
	end

	analog begin
		initial begin
			if(T == 2) T = 3;
		end
	end
endmodule
