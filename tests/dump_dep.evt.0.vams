`include "disciplines.vams"
`include "constants.vams"
`pragma modelgen dump-annotate
`pragma modelgen nodump-nature
`pragma modelgen nodump-discipline

module test_idt3a(p, n);
	electrical p, n;
	integer rst;
	analog begin
		rst = 0;
		@(timer(1, 1)) begin
			rst = 1;
			$discontinuity();
		end
		V(p, n) <+ idt(1.0, 0, rst);
	end
endmodule
