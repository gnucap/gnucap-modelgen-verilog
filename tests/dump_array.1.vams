`include "disciplines.vams"
`pragma modelgen nodump-nature
`pragma modelgen nodump-discipline

module test_array(p, n);
	(* desc="" *) real dv;
	electrical p, n;
	analog begin
		dv = exp('{1.,2,3,1+2, '{"nest", 17} });
	end
endmodule
