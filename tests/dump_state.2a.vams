`include "disciplines.vams"
`include "constants.vams"
`pragma modelgen dump-annotate
`pragma modelgen nodump-nature
`pragma modelgen nodump-discipline
`pragma modelgen nodump-module

module st(p);
  inout      p;
  electrical p;
  parameter real x=1;
  analog begin : main
    (* _state *) real c;
    if(x) begin
		 c = c + 1;
    end
    V(p) <+ c;
  end
endmodule

paramset st1 st
 .x = 1;
endparamset;
paramset st0 st
 .x = 0;
endparamset;
