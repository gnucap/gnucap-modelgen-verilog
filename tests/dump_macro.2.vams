`define thing

`ifdef thing
module reached0;
endmodule
`ifdef thing
module reached1;
endmodule
`else
notreached
`endif // B
module reached2;
endmodule
`else
notreached
`endif
