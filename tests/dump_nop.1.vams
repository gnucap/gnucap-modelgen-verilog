`include "sub/disciplines.few"
`pragma modelgen dump-unreachable

module test(a, b);
	electrical a, b;
	parameter real arg=0 from [0.:0.];
	real T;
	real U;
	analog begin
		if(0)
			V(a) <+ 1.;
		else
			V(a) <+ 2.;

		if(arg)
			V(b) <+ 3.;

		if(0==1)
			V(a) <+ 4.;

		case(arg)
			0: V(b) <+ 2.2;
			default:
		endcase
	end
endmodule
