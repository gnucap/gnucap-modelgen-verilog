`include "sub/disciplines.few"
`pragma modelgen dump-unreachable

module test(a, b);
	electrical a, b;
	parameter real arg=0 from [0.:0.];
	real T;
	real U;
	analog begin
		if(0)
			V(a) <+ 1;
		else
			V(a) <+ 2;

		if(arg)
			V(b) <+ 1;
	end
endmodule
