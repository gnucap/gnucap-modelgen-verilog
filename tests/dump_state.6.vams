`include "disciplines.vams"
`include "constants.vams"
`pragma modelgen dump-annotate
`pragma modelgen nodump-nature
`pragma modelgen nodump-discipline

module test_init4(p, n);
	electrical p, n;
	real s = 17;
	real t = 42;
	analog initial begin
	  t=17;
	end
	analog begin
		$debug("%g %g\n", t, s);
	end
endmodule
