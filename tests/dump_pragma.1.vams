`include "sub/disciplines.few"
`pragma modelgen nodump-module
`pragma modelgen noexpand-paramset

module resistor(a,b)
	electrical a, b;

	parameter real r=1;

	analog begin
		I(a,b) <+ V(a,b)/r;
	end
endmodule

paramset const_res resistor;
//	.r = 1;
endparamset;
