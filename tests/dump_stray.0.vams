module warn
analog begin
@(initial_step)
 begin
 end;
end
endmodule
