`include "sub/disciplines.few"
`pragma modelgen expand-paramset
`pragma modelgen nodump-module

module resistor(a,b)
	electrical a, b;

	parameter real r = 1.;
	localparam real l = r;

	analog begin
		I(a,b) <+ V(a,b)/l;
	end
endmodule

paramset my_res resistor;
	parameter real r = 1.;
	.r = r;
endparamset;
