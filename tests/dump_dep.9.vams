`include "disciplines.vams"
`include "constants.vams"
`pragma modelgen dump-annotate
`pragma modelgen nodump-nature
`pragma modelgen nodump-discipline

module test_diode1(a, c);
	inout a, c;
	electrical a, c;
	parameter real x=0;

	analog begin
		real a, b;

		if(x <= 0.) begin
			a = V(a, c);
		end else begin
			a = I(a, c);
			b = a;
		end

	end
endmodule
