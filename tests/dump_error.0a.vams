// Linear resistor (conductance formulation)

nature Voltage
   units       = "V";
   access      = X;
endnature
nature Current
    units      = "A";
    access     = I;
endnature
discipline electrical
   flow          Current;
   potential     Voltage;
enddiscipline

module error0 (p, n);
	inout p, n;
	electrical p, n;
	real v;

	analog
		I(p,n) <+ X(p,n);

	analog
		real X;
		v = X(x,y);
endmodule
