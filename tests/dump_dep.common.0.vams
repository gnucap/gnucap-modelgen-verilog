`include "disciplines.vams"
`include "constants.vams"
`pragma modelgen dump-annotate
`pragma modelgen nodump-nature
`pragma modelgen nodump-discipline

module test_seq0(p, n);
	electrical p, n;
	inout p, n;
	parameter real v=0;
	analog begin : main
		real i;
		i = 0;
		if(v==0) begin
			i = 1;
		end else begin
			i = 2;
		end
		V(p, n) <+ i;
	end
endmodule
