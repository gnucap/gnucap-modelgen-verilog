`define mwa(a, b, c) module c; endmodule

`mwa(1,1,2,3)
