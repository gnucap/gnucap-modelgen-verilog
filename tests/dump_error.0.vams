// Linear resistor (conductance formulation)

nature Voltage
   units       = "V";
   access      = V;
endnature
nature Current
    units      = "A";
    access     = I;
endnature
discipline electrical
   flow          Current;
   potential     Voltage;
enddiscipline

module error0 (p, n);
	inout p, n;
	electrical p, n;

	analog
		I(p,n) <+ V(x,y);
endmodule
