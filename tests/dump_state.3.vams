`include "disciplines.vams"
`include "constants.vams"
`pragma modelgen dump-annotate
`pragma modelgen nodump-nature
`pragma modelgen nodump-discipline

module base(p, n);
  electrical p, n;
  (* desc="y"*) real y;
  analog begin
    y = V(p,n) - 1;
  end
endmodule
paramset test_ps3a base
  (* desc="y"*) real y;
  y = 9;
endparamset
