// Linear resistor (conductance formulation)

`include "sub/disciplines.few"

module conductor0 (p, n);
	inout p, n;
	electrical p, n;

	analog
		I(p,n) <+ V(p,n);
endmodule
