module test()
	analog begin
		XS(n, p) <+ 17.
	end
endmodule
