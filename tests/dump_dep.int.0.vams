`include "disciplines.vams"
`include "constants.vams"
`pragma modelgen dump-annotate
`pragma modelgen nodump-nature
`pragma modelgen nodump-discipline

module dep0(d, g);

    inout      d, g;
    electrical d, g;

    analog begin: main
        real c;
        integer T;

        T = V(g);
        c = T;
        I(d) <+ c;
    end

endmodule
