module test(x, y)

analog begin : main
real A, LEVEL;
case (LEVEL)
  1 : A = 1;
  default : A = 2;
  2 : A = 3;
  default : A = 2;
endcase

endmodule
