`include "disciplines.vams"
`pragma modelgen nodump-nature
`pragma modelgen nodump-discipline

module vcsw (p, n, cp, cn);
	inout p, n, cp, cn;
	electrical p, n, cp, cn;
	parameter real th = 0;
	analog begin
		@(cross(V(cp, cn) - th, 0) or cross(V(cp,cn)+th, 0));
		@(cross(V(cp, cn) - th, 0), cross(V(cp,cn)+th, 0));
		if (V(cp, cn) > th) V(p, n) <+ 0;
	end
endmodule
