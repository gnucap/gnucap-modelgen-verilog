`include "disciplines.vams"
`include "constants.vams"
`pragma modelgen dump-annotate
`pragma modelgen nodump-nature
`pragma modelgen nodump-discipline

module test_strobe3(a, b);
  inout a, b;
  electrical a, b;
  parameter integer p = 1 from [0:1];
  integer P;

    analog begin
        begin
            P = p;

            if (P ==1) begin
            end
            else
                $strobe("BUG");
        end
    end
endmodule
