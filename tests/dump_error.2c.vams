`include "sub/disciplines.few"

module test()
   real i;
   analog begin
   for(j=0; 0; i=i+1) begin
   end
endmodule;
