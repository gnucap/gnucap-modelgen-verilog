module test()
	analog begin
		real t;
		t = $abstime;
		t = $abstime();
	end
endmodule
