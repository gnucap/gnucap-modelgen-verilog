module test()
	analog begin : main
		real t;
		t = $abstime;
		t = $abstime();
	end
endmodule
