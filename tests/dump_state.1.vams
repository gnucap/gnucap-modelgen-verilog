`include "disciplines.vams"
`include "constants.vams"
`pragma modelgen dump-annotate
`pragma modelgen nodump-nature
`pragma modelgen nodump-discipline

module st(p);
  inout      p;
  electrical p;
  analog begin : main
    real c;
    if(0) begin
		 c = c + 1;
    end
  end
endmodule
