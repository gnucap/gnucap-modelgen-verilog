module test1(in, out);
input in;
output out;
wire foo;
assign out = !in;
assign out = !in, foo = !out;
endmodule

module test2(in, out);
input in;
output out;
wire foo;
wire en;
assign #3 out = !in, foo = !out;
assign #17 en = 1;
endmodule
