// BUG // suboptimal error message
module test()

	analog begin
		$strobetypo(0);
	end

endmodule
