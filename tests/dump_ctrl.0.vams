`include "sub/disciplines.few"

`pragma modelgen dump-annotate
`pragma modelgen dump-unreachable
`pragma modelgen nooptimize-unused

module cond0(p,n);
	analog begin : main
		real S, T, U;
		if (1.);
		if (1 + S == 3);
		if (1==1);
   end
endmodule

module cond1(p,n);
	analog begin : main
		real S;
		if (1==1) begin
			S = 3;
		end else begin : bla
			S = 1;
		end
		if (1==0) begin
			S = 3;
		end else begin : bla
			S = 1;
		end
   end

endmodule

module cond2(p,n);
	analog begin : main
		real S;
		real T;
		if(1 == exp(1.)) S = 1;
		if(1 == exp(0.))
			T = 1;
		else if ( 2==1 ) begin
			T = 2;
		end
	end
endmodule

module cond3(p,n);
	analog begin : main
		real S;
		real T;
		if(1) begin
			if(2) begin
				S=2;
			end
		end
		if(1) if(2) if(3) if(4) if(5) begin
			T = 1;
		end else if(5) T=3;

		if(T) begin
			T=0;
		end else begin
			T=2;
		end

    if(1) begin
      if(2) begin
        S=2;
      end else begin
        S=1;
      end
    end else begin
      S=1;
    end

	end
endmodule

module cond4(p,n);
	analog begin : main
		real S;
		real T;
		if(1) begin
			if(2) begin
			end else begin
			end
		end else begin
		end
	end
endmodule

module cond5(p,n);
	analog begin : main
		real S;
		real T;
		integer i;
		i = 1;
		if(i) begin
			// TODO: always.
			i = 2;
		end else begin
			i = 3;
		end
	end
endmodule
