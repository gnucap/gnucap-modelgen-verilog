`include "disciplines.vams"
`include "constants.vams"
`pragma modelgen dump-annotate
`pragma modelgen nodump-nature
`pragma modelgen nodump-discipline

module test_gmin (a, c);
   inout a, c;
   electrical a, c;
   real gg;

   analog begin
		gg = $simparam("gmin",0.0);
		I(a,c) <+ gg * V(a,c);
	end
endmodule
