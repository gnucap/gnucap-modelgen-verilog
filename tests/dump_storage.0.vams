`include "disciplines.vams"
`include "constants.vams"
`pragma modelgen dump-annotate
`pragma modelgen nodump-nature
`pragma modelgen nodump-discipline

module test_state (a, c);
   parameter integer init=0;

   inout a, c;
   electrical a, c;
   electrical ia;
   real vv;

   analog initial begin
      vv = init;
   end

   analog begin
		V(a,c) <+ transition(vv);
		vv = vv + 1;
	end
endmodule
