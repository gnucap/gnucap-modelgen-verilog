`include "disciplines.vams"
`include "constants.vams"
`pragma modelgen dump-annotate
`pragma modelgen nodump-nature
`pragma modelgen nodump-discipline

module dep7(d, g);
  inout      d, g;
  electrical d, g;
  real T;
  parameter real p = 0.;
  analog begin : main
    real c;
    @(initial_step) begin
      if ((! $param_given(p))) begin
        c=1.;
      end
    end
    T = c;
    I(d,g)<+c;
  end

endmodule
