`include "sub/disciplines.few"
`pragma modelgen expand-paramset

module resistor(a,b)
	electrical a, b;

	parameter real r = 1.;
	aliasparam R = r;

	analog begin
		I(a,b) <+ V(a,b)/r;
	end
endmodule

paramset my_res resistor;
	parameter real r = 1.;
	.r = r;
endparamset;

// paramset my_res resistor;
// 	parameter real R = 1.;
// 	.R = R;
// endparamset;
