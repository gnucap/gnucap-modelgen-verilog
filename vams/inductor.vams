`include "disciplines.vams"

(*desc="vams inductor"*)
module inductor(p,n);
	inout p,n;
	electrical p,n;

	parameter real l = 1. from [0.:inf);
	parameter string which = "vams" from '{"vams"};

	analog begin
		I(p,n) <+ idt(V(p,n)) / l;
	end
endmodule

(*desc="vams inductor w/ ic"*)
module inductor(p,n);
	inout p,n;
	electrical p,n;

	parameter real l = 1. from [0.:inf);
	parameter real ic = 0.;

	analog begin
		I(p,n) <+ idt(V(p,n), ic*l) / l;
	end
endmodule
