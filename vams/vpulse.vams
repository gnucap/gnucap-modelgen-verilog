// (c) Felix Salfelder 2024
// GPLv3+
`include "disciplines.vams"
`include "constants.vams"

module vpulse(p, n);
	output p, n;
	electrical p, n;
	parameter real dc    =0.;
	parameter real mag   =1.;
	parameter real phase =0.;
	parameter real val0  =0.;
	parameter real val1  =1.;
	parameter real td    =0.;
	parameter real rise  =0.;
	parameter real fall  =0.;
	parameter real width =1.;
	parameter real period=2.;
	(*desc="i"*) real i;
	(*desc="v"*) real v;
	analog begin
		begin : evt
		   @(timer(td + width + rise, period)) begin
		   	v = val0;
		   end
			@(timer(td,  period)) begin
				v = val1;
			end
		end

		if(analysis("static") && $param_given(dc)) begin
         // BUG in Table E.1. not sure what dc is used for.
			v = dc;
		end
		V(p,n) <+ transition(v, 0., rise, fall);
		i = I(p,n);
	end
endmodule
