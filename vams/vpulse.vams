// (c) Felix Salfelder 2024
// GPLv3+
`include "disciplines.vams"
`include "constants.vams"

module vpulse(p, n);
	output p, n;
	electrical p, n;
	parameter real dc    =0.;
	parameter real mag   =1.;
	parameter real phase =0.;
	parameter real val0  =0.;
	parameter real val1  =1.;
	parameter real td    =0.;
	parameter real width =1.;
	parameter real period=2.;
	(*desc="i"*) real i;
	(*desc="v"*) real v;
	analog begin
		begin : evt
		//end begin
			// TODO: need "transition".
		   @(timer(td + width, period)) begin
		   //	$write("off %g\n", $abstime);
		   	v = val0;
		   //	$discontinuity;
		   end
			@(timer(td,  period)) begin
			//	$write("on %g\n", $abstime);
				v = val1;
			//	$discontinuity;
			end
		end

		if(analysis("static") && $param_given(dc)) begin
			v = dc;
		end
		//$debug("AA %g %g\n", $abstime, v);
		V(p,n) <+ v;
		i = I(p,n);
	end
endmodule
