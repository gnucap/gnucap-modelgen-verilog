// (c) Felix Salfelder 2023, 2024
// GPLv3+
`include "disciplines.vams"
`include "constants.vams"

(*desc="vams vsine"*)
module vsine(p, n);
	output p, n;
	electrical p, n;
	parameter real freq  =1. from [0:inf);
	parameter real ampl  =1.;
	parameter real offset=0.;
	parameter real phase =0.;
	parameter real dc    =0.;
	parameter real mag   =1.;
	parameter real samples = 4. from (0:inf);
	(*desc="i"*) real i;
	analog begin
		if(analysis("dc") && $param_given(dc)) begin
			V(p, n) <+ dc;
		end else begin
			V(p, n) <+ ampl*sin(`M_TWO_PI*freq*$abstime - phase) + offset;
			$bound_step(1./(freq*samples));
		end
		i = I(p,n);

		V(p, n) <+ ac_stim("ac", mag);
	end
endmodule
