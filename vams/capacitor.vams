`include "disciplines.vams"

module capacitor(p,n);
	inout p,n;
	electrical p,n;

	parameter real c = 1. from [0:inf);
	analog begin
		I(p,n) <+ c * ddt(V(p,n));
	end
endmodule
