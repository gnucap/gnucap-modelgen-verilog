// Copyright 2013, 2023 Felix Salfelder
// GPLv3+
// voltage controlled voltage source

`include "disciplines.vams"

module vcvs(p,n,cp,cn);
	inout p,n,cp,cn;
	electrical p,n,cp,cn;

   parameter real gain    = 1. from [0:inf);
   parameter real offset  = 0.;

   real loss;
   analog begin
      V(p,n) <+ gain*V(cp,cn) + offset;
   end
endmodule
