// constants for use in verilog-ams
// essentially a copy of gnucap/include/constants.h (GPLv3+)

// standard mathematical constants
`define M_PI 3.1415926535897932384626433832795028841972
`define M_TWO_PI (`M_PI * 2.)
//double const M_E	= 2.7182818284590452354;
//double const M_LOG2E	= 1.4426950408889634074;  // log2(M_E)
//double const M_LOG10E	= 0.43429448190325182765; // log10(M_E)
//double const M_LN2	= 0.69314718055994530942; // log(2)
//double const M_LN10	= 2.3025809299404568402;  // log(10)

`define M_SQRT2 1.4142135623730904880  // sqrt(2)
//double const M_SQRT1_2  = 1 / M_SQRT_2;

// standard physical constants ref:  http://physics.nist.gov
// `define P_Q	1.6021918e-19   // charge of an electron, (spice)
`define P_Q	1.60217653e-19     // charge of an electron, (nist)
// `define P_C	2.99792458e8    // speed of light m/s
// `define P_K	1.3806226e-23   // Boltzmann's constant J/K (spice)
`define P_K	1.3806505e-23      // Boltzmann's constant J/K (nist)
// `define P_H	6.6260693e-34   // Planck's constant J-s
`define P_U0 M_PI * 4.0e-7  // permeability of vaccuum H/m
// `define P_EPS0	8.854214871e-12; // permittivity of air F/m(spice)
`define P_EPS0	8.854187817e-12 // permittivity of vaccuum F/m(nist)
// `define const P_EPS0 1/(P_U0*P_C*P_C);// permittivity of vaccuum F/m(nist)
`define P_CELSIUS0 273.15	   // 0 Celsius

// CMC 1.3.0 section 12
`define P_Q_NIST2018 1.602176634e-19
`define P_K_NIST2018 1.380649e-23

// from https://physics.nist.gov/cuu/pdf/all_1998.pdf
`define P_Q_NIST1998 = 1.602176462e-19;
`define P_K_NIST1998 = 1.3806503e-23;

// extra physical constants from constant.h
`define P_EPS_SI 11.7*`P_EPS0 // permittivity of silicon (1.0359e-10)
`define P_EPS_OX 3.9*`P_EPS0  // permittivity of oxide (3.45e-11)
`define P_K_Q (`P_K/`P_Q)

// dimension conversions.
// Hopefully, all internal distances are in meters.
// (except for some Berkeley models)
// In some cases the user data is in other units
`define CM2M    1e-2;	//	centimeters to meters 	 */
`define CM2M2   1e-4;	//          ...........  squared */
`define ICM2M   1e2;		// inverse  ...........    	 */
`define ICM2M2  1e4;		// inverse  ...........  squared */
`define ICM2M3  1e6;		// inverse  ...........  cubed   */
`define MICRON2METER = 1e-6;	//	microns to meters	 */
