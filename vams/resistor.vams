`include "disciplines.vams"
`include "constants.vams"

(*desc="vams resistor"*)
module resistor(p, n);
	electrical p, n;
	inout p, n;
	parameter real r = 1. from [0.:inf);
	parameter real tc1 = 0., tc2 = 0.;
	parameter real noisy = 0. from [0:1];   // nspice
	parameter real tnom = 0.; // nonstandard ..
	aliasparam m = $mfactor;
	(* desc="i" *) real i;
	analog begin : main
		real dt, g;
		if($param_given(tnom)) begin
			 dt = $temperature - tnom;
		end
		if($param_given(tc1) || $param_given(tc2)) begin
			g = 1. / (r * (1.+(tc1+tc2*dt)*dt));
		end else begin
			g = 1. / r;
		end
		i = V(p,n) * g;
		I(p,n) <+ i;
		I(p,n) <+ white_noise(noisy * 4 * `P_K * g * $temperature, "thermal");
	end
endmodule

(*desc="vams resistor, plain"*)
paramset resistor resistor
	parameter real r = 1. from [0.:inf);
	.r = r;
endparamset
